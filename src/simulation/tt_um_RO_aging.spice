** sch_path: /foss/designs/SKY130A/tt_um_Onchip_Ring_Oscillators_Aging/src/tt_um_RO_aging.sch
.subckt tt_um_RO_aging uio_in[7] uio_in[6] uio_in[5] uio_in[4] uio_in[3] uio_in[2] uio_in[1] uio_in[0] ui_in[7] ui_in[6] ui_in[5]
+ ui_in[4] ui_in[3] ui_in[2] ui_in[1] ui_in[0] rst_n clk ena ua[7] ua[6] ua[5] ua[4] ua[3] ua[2] ua[1] ua[0] VDPWR VGND
*.PININFO uio_in[7:0]:B ui_in[7:0]:B clk:B rst_n:B ena:B ua[7:0]:B VGND:B VDPWR:B
x1 VDPWR VGND ua[2] ua[3] ua[5] ua[4] ui_in[0] ui_in[1] ua[1] net1 RO_LVT_13St_x1
x2 VDPWR ua[0] net1 VGND DIV
* noconn ua[7:6]
* noconn ui_in[7:2]
* noconn #net2
* noconn rst_n
* noconn ena
* noconn clk
* noconn uio_in[7:0]
.ends

* expanding   symbol:  /foss/designs/SKY130A/tt_um_Onchip_Ring_Oscillators_Aging/src/RO_LVT_13St_x1.sym # of pins=10
** sym_path: /foss/designs/SKY130A/tt_um_Onchip_Ring_Oscillators_Aging/src/RO_LVT_13St_x1.sym
** sch_path: /foss/designs/SKY130A/tt_um_Onchip_Ring_Oscillators_Aging/src/RO_LVT_13St_x1.sch
.subckt RO_LVT_13St_x1 VDD GND DUT_Footer DUT_Header Drain_Sense Drain_Force RO RON DUT_Gate OUT
*.PININFO DUT_Footer:B DUT_Header:B Drain_Sense:B Drain_Force:B RON:B RO:B DUT_Gate:B OUT:B GND:B VDD:B
x1[1] VDD GND A[7] A[8] rovcel2_LVT
x1[2] VDD GND A[6] A[7] rovcel2_LVT
x1[3] VDD GND A[5] A[6] rovcel2_LVT
x1[4] VDD GND A[4] A[5] rovcel2_LVT
x1[5] VDD GND A[3] A[4] rovcel2_LVT
x1[6] VDD GND A[2] A[3] rovcel2_LVT
x1[7] VDD GND A[1] A[2] rovcel2_LVT
x1[8] VDD GND OUT A[1] rovcel2_LVT
x2 VDD GND A[8] A[9] rovcel2_LVT
x6 VDD GND A[12] OUT rovcel2_LVT
x3 VDD GND RON A[9] A[10] RO DUT_Gate rovcel3_LVT
x4 VDD A[12] GND RON A[11] rovcel4_LVT
x1 VDD GND Drain_Sense DUT_Footer DUT_Header Drain_Force A[10] A[11] RON RO rovcel1_x1_LVT
.ends

* expanding   symbol:  /foss/designs/SKY130A/tt_um_Onchip_Ring_Oscillators_Aging/src/DIV.sym # of pins=4
** sym_path: /foss/designs/SKY130A/tt_um_Onchip_Ring_Oscillators_Aging/src/DIV.sym
** sch_path: /foss/designs/SKY130A/tt_um_Onchip_Ring_Oscillators_Aging/src/DIV.sch
.subckt DIV VDD OUT IN GND
*.PININFO GND:B IN:B VDD:B OUT:B
x1[0] VDD A[0] A[0] net2 IN GND FF
* noconn #net2
x1[1] VDD A[1] A[1] net3 A[0] GND FF
* noconn #net3
x1[11] VDD OUT OUT net1_8 A[10] GND FF
x1[10] VDD A[10] A[10] net1_7 A[9] GND FF
x1[9] VDD A[9] A[9] net1_6 A[8] GND FF
x1[8] VDD A[8] A[8] net1_5 A[7] GND FF
x1[7] VDD A[7] A[7] net1_4 A[6] GND FF
x1[6] VDD A[6] A[6] net1_3 A[5] GND FF
x1[5] VDD A[5] A[5] net1_2 A[4] GND FF
x1[4] VDD A[4] A[4] net1_1 A[3] GND FF
x1[3] VDD A[3] A[3] net1_0 A[2] GND FF
* noconn #net1
x1[2] VDD A[2] A[2] net4 A[1] GND FF
* noconn #net4
.ends

* expanding   symbol:  /foss/designs/RO_Aging_UNICASS/LVT/rovcel2_LVT/rovcel2_LVT.sym # of pins=4
** sym_path: /foss/designs/RO_Aging_UNICASS/LVT/rovcel2_LVT/rovcel2_LVT.sym
** sch_path: /foss/designs/RO_Aging_UNICASS/LVT/rovcel2_LVT/rovcel2_LVT.sch
.subckt rovcel2_LVT VDD GND IN OUT
*.PININFO OUT:B IN:B VDD:B GND:B
* noconn #net1
* noconn #net2
x1 VDD IN OUT GND inv_LVT
x2 VDD OUT net1 GND GND VDD passgate_LVT
x3 VDD OUT net2 GND GND VDD passgate_LVT
.ends

* expanding   symbol:  /foss/designs/RO_Aging_UNICASS/LVT/rovcel3_LVT/rovcel3_LVT.sym # of pins=7
** sym_path: /foss/designs/RO_Aging_UNICASS/LVT/rovcel3_LVT/rovcel3_LVT.sym
** sch_path: /foss/designs/RO_Aging_UNICASS/LVT/rovcel3_LVT/rovcel3_LVT.sch
.subckt rovcel3_LVT VDD GND RON IN OUT RO DUT_Gate
*.PININFO OUT:B DUT_Gate:B RON:B RO:B IN:B VDD:B GND:B
M0 net2 RO GND GND sky130_fd_pr__nfet_01v8_lvt L=0.35 W=2.1 nf=1 m=20
M1 OUT IN net2 GND sky130_fd_pr__nfet_01v8_lvt L=0.35 W=2.1 nf=1 m=2
M2 OUT IN net1 VDD sky130_fd_pr__pfet_01v8_lvt L=0.35 W=4.75 nf=1 m=4
M3 net1 RON VDD VDD sky130_fd_pr__pfet_01v8_lvt L=0.35 W=4.75 nf=1 m=40
* noconn #net3
x2 RO OUT net3 RON GND VDD passgate_LVT
x3 RO OUT DUT_Gate RON GND VDD passgate_LVT
.ends

* expanding   symbol:  /foss/designs/RO_Aging_UNICASS/LVT/rovcel4_LVT/rovcel4_LVT.sym # of pins=5
** sym_path: /foss/designs/RO_Aging_UNICASS/LVT/rovcel4_LVT/rovcel4_LVT.sym
** sch_path: /foss/designs/RO_Aging_UNICASS/LVT/rovcel4_LVT/rovcel4_LVT.sch
.subckt rovcel4_LVT VDD OUT GND RON IN
*.PININFO OUT:B RON:B IN:B GND:B VDD:B
M1 OUT IN GND GND sky130_fd_pr__nfet_01v8_lvt L=0.35 W=2.1 nf=1 m=2
M2 OUT IN net1 VDD sky130_fd_pr__pfet_01v8_lvt L=0.35 W=4.75 nf=1 m=4
M3 net1 RON VDD VDD sky130_fd_pr__pfet_01v8_lvt L=0.35 W=4.75 nf=1 m=40
* noconn #net2
x2 VDD OUT net2 RON GND VDD passgate_LVT
x3 VDD OUT GND RON GND VDD passgate_LVT
.ends

* expanding   symbol:  /foss/designs/RO_Aging_UNICASS/LVT/rovcel1_x1_LVT/rovcel1_x1_LVT.sym # of pins=10
** sym_path: /foss/designs/RO_Aging_UNICASS/LVT/rovcel1_x1_LVT/rovcel1_x1_LVT.sym
** sch_path: /foss/designs/RO_Aging_UNICASS/LVT/rovcel1_x1_LVT/rovcel1_x1_LVT.sch
.subckt rovcel1_x1_LVT VDD GND Drain_Sense DUT_Footer DUT_Header Drain_Force IN OUT RON RO
*.PININFO OUT:B Drain_Force:B DUT_Footer:B DUT_Header:B IN:B Drain_Sense:B VDD:B GND:B RO:B RON:B
M0 net2 DUT_Header GND GND sky130_fd_pr__nfet_01v8_lvt L=0.35 W=2.1 nf=1 m=20
M1 OUT IN net2 GND sky130_fd_pr__nfet_01v8_lvt L=0.35 W=2.1 nf=1 m=2
M2 OUT IN net1 VDD sky130_fd_pr__pfet_01v8_lvt L=0.35 W=4.75 nf=1 m=4
M3 net1 DUT_Footer VDD VDD sky130_fd_pr__pfet_01v8_lvt L=0.35 W=4.75 nf=1 m=40
M4 Drain_Force RON OUT GND sky130_fd_pr__nfet_01v8_lvt L=0.35 W=0.42 nf=1
M5 Drain_Sense RON OUT GND sky130_fd_pr__nfet_01v8_lvt L=0.35 W=0.42 nf=1
M6 Drain_Sense RO OUT VDD sky130_fd_pr__pfet_01v8_lvt L=0.35 W=1.9 nf=1
M7 Drain_Force RO OUT VDD sky130_fd_pr__pfet_01v8_lvt L=0.35 W=1.9 nf=1
.ends

* expanding   symbol:  /foss/designs/chipathon_2025/designs/sky130/DIV/FF/FF.sym # of pins=6
** sym_path: /foss/designs/chipathon_2025/designs/sky130/DIV/FF/FF.sym
** sch_path: /foss/designs/chipathon_2025/designs/sky130/DIV/FF/FF.sch
.subckt FF VDD D Q_N Q CLK GND
*.PININFO GND:B CLK:B VDD:B Q:B Q_N:B D:B
x1 CLKN VDD net1 D GND CLK passgate_DIV
x2 VDD net2 net1 GND inv_DIV
x3 CLK VDD net1 net4 GND CLKN passgate_DIV
x4 VDD net4 net2 GND inv_DIV
x5 CLK VDD net3 net2 GND CLKN passgate_DIV
x6 VDD net5 net3 GND inv_DIV
x7 CLKN VDD net3 Q_N GND CLK passgate_DIV
x8 VDD Q Q_N GND inv_DIV
x10 VDD CLKN CLK GND inv_DIV
x9 VDD Q_N net5 GND inv_DIV
.ends

* expanding   symbol:  /foss/designs/RO_Aging_UNICASS/LVT/inv_LVT/inv_LVT.sym # of pins=4
** sym_path: /foss/designs/RO_Aging_UNICASS/LVT/inv_LVT/inv_LVT.sym
** sch_path: /foss/designs/RO_Aging_UNICASS/LVT/inv_LVT/inv_LVT.sch
.subckt inv_LVT VDD IN OUT GND
*.PININFO VDD:B IN:B OUT:B GND:B
M1 OUT IN GND GND sky130_fd_pr__nfet_01v8_lvt L=0.35 W=2.1 nf=1 m=2
M2 OUT IN VDD VDD sky130_fd_pr__pfet_01v8_lvt L=0.35 W=4.75 nf=1 m=4
.ends

* expanding   symbol:  /foss/designs/RO_Aging_UNICASS/LVT/passgate_LVT/passgate_LVT.sym # of pins=6
** sym_path: /foss/designs/RO_Aging_UNICASS/LVT/passgate_LVT/passgate_LVT.sym
** sch_path: /foss/designs/RO_Aging_UNICASS/LVT/passgate_LVT/passgate_LVT.sch
.subckt passgate_LVT CLKN IN OUT CLK GND VDD
*.PININFO CLKN:B CLK:B IN:B OUT:B VDD:B GND:B
M3 IN CLK OUT GND sky130_fd_pr__nfet_01v8_lvt L=0.35 W=0.45 nf=1
M1 IN CLKN OUT VDD sky130_fd_pr__pfet_01v8_lvt L=0.35 W=0.45 nf=1
.ends

* expanding   symbol:  /foss/designs/chipathon_2025/designs/sky130/DIV/passgate_DIV/passgate_DIV.sym # of pins=6
** sym_path: /foss/designs/chipathon_2025/designs/sky130/DIV/passgate_DIV/passgate_DIV.sym
** sch_path: /foss/designs/chipathon_2025/designs/sky130/DIV/passgate_DIV/passgate_DIV.sch
.subckt passgate_DIV CLKN VDD OUT IN GND CLK
*.PININFO VDD:B OUT:B GND:B IN:B CLKN:B CLK:B
M3 IN CLK OUT GND sky130_fd_pr__nfet_01v8 L=0.15 W=0.65 nf=1
M1 IN CLKN OUT VDD sky130_fd_pr__pfet_01v8 L=0.15 W=1 nf=1
.ends

* expanding   symbol:  /foss/designs/chipathon_2025/designs/sky130/DIV/inv_DIV/inv_DIV.sym # of pins=4
** sym_path: /foss/designs/chipathon_2025/designs/sky130/DIV/inv_DIV/inv_DIV.sym
** sch_path: /foss/designs/chipathon_2025/designs/sky130/DIV/inv_DIV/inv_DIV.sch
.subckt inv_DIV VDD OUT IN GND
*.PININFO VDD:B OUT:B GND:B IN:B
M3 OUT IN GND GND sky130_fd_pr__nfet_01v8 L=0.15 W=1 nf=1
M1 OUT IN VDD VDD sky130_fd_pr__pfet_01v8 L=0.15 W=2 nf=1
.ends

.GLOBAL VDD
.GLOBAL GND
